* Diode Load Netlist
.TITLE Diode Load CS Amplifier
.END
