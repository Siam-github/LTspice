* PMOS Driver Netlist
.TITLE PMOS Driver CS Amplifier
.END
