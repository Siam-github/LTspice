* Current Source Load Netlist
.TITLE Current Source Load CS Amplifier
.END
